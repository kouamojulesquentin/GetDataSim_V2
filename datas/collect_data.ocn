simulator('spectre)
design("f" "f" "f")

analysis('tran ?stop "10")
desVar("R" 4)
desVar("L" 4)
desVar("C" 4)
paramAnalysis("R" ?values '(4.12559679 3.91042475 3.89196152 4.13424882 4.02263581 )
paramAnalysis("L" ?values '(4.08957635 4.09986644 3.95010738 3.99235127 4.07725394 )
paramAnalysis("C" ?values '(4.15733074 3.9207852 3.98295246 4.14876608 3.95027346 )
)))
paramRun()
selectResult('tran)
ocnPrint(getData("/V_in") ?output "/home/kouamoj/Documents/GetDataSim_V2/datas/V_in.txt" ?from 0 ?to 10 ?step 0.01)
ocnPrint(getData("/V_out") ?output "/home/kouamoj/Documents/GetDataSim_V2/datas/V_out.txt" ?from 0 ?to 10 ?step 0.01)
plot(getData("/V_in") getData("/V_out"))
