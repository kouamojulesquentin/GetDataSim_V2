simulator('spectre)
design("rlc_filter" "rlc_filter" "schematic")

analysis('tran ?stop "10")
desVar("R" 89)
desVar("L" 0.015)
desVar("C" 9.5e-05)
paramAnalysis("R" ?values '(95.8616816 82.6249533 93.8429523 80.2911462 84.2473457 85.5340618 93.8319383 85.0985411 87.7582427 86.3527365 95.1513375 )
paramAnalysis("L" ?values '(0.0171849398 0.0162916532 0.0159079254 0.0167926626 0.0167122 0.0132183492 0.0130487933 0.0134057908 0.0156513138 0.014052852 0.0169338578 )
paramAnalysis("C" ?values '(9.13152588e-05 9.2836752e-05 9.04719616e-05 8.76674386e-05 7.31924597e-05 0.000110007873 0.000115204455 8.62743791e-05 0.000112894584 0.000111081737 0.000112357033 )
)))
paramRun()
selectResult('tran)
ocnPrint(getData("/V_in") ?output "/tima/kouamoj/Documents/vituoso/rlc_filter/GetDataSim/datas/V_in.txt" ?from 0 ?to 10 ?step 0.01)
ocnPrint(getData("/V_out") ?output "/tima/kouamoj/Documents/vituoso/rlc_filter/GetDataSim/datas/V_out.txt" ?from 0 ?to 10 ?step 0.01)
plot(getData("/V_in") getData("/V_out"))
